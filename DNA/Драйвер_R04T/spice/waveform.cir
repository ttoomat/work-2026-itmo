* HV R0.4-T — waveform
.include core.inc
.include input_bessel4.inc
.tran 2n 64u 0 2n
.save v(vin) v(out) v(preout) v(drive) v(up) v(down)
.end
