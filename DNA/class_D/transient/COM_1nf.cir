* Manual user run: complete power/controller loop; engineering linear input stage.
* Prototype development - controller and selectable power-stage models; not PCB release
.param FSW=6Meg TPER=1/FSW LPH=500n CFIX=468n CNOM=480n
.param KP=4 KD=0.25u KI=10000000 TF=25n TDIF=5n
.param TDELAY=13.5n TDEAD=5n
Vground sysgnd 0 10
Vbus bus 0 60
Vref ref 0 PWL(0u 10 2u 10 7u 21.3 10u 21.3 13u 21.3 14u 7.2 18.2u 7.2 21u 21.3 24u 21.3 26.5u 28.2 27.7u 28.2 30.2u 21.3 32u 21.3 35u 51.8 38.5u 51.8 41.5u 7.2 44.5u 7.2 45.5u 21.3 49u 21.3)
Vinput input sysgnd PWL(0u 0.231252118838 2u 0.231252118838 7u 0.829934359191 10u 0.829934359191 13u 0.829934359191 14u 0.0829060769801 18.2u 0.0829060769801 21u 0.829934359191 24u 0.829934359191 26.5u 1.19550139091 27.7u 1.19550139091 30.2u 0.829934359191 32u 0.829934359191 35u 2.44584660085 38.5u 2.44584660085 41.5u 0.0829060769801 44.5u 0.0829060769801 45.5u 0.829934359191 49u 0.829934359191)
.include "../models/compatible/OPA859.lib"
Vlogic logic 0 5
Vmid mid 0 1.65
* OPA2192 linear input model: 10 MHz GBP, 2 channels, RC input.
* Actual resistor circuit and original TI macro-model: frontend_check.py.
Vaux aux15 sysgnd 5
Ifront aux15 0 2m
Rinput input fi 100
Cinput fi sysgnd 47p
Ebuffer eb 0 fi 0 1
Rbuffer eb b 1k
Cbuffer b 0 15.9154943p
Blevel lev 0 V=0.626653733867*V(b)-0.59332*V(sysgnd)-0.0808117679107*V(mid)
Rlevel lev lv 1k
Clevel lv 0 2.6644634625e-11
Enorm rnorm 0 lv 0 1

Rplus rnorm plus 249
Cref_filter plus mid 1.6n
Rbias mid plus 2.94k
Rfb error minus 2.94k
RmeasureA out minus 15k
RmeasureB out minus 15k
RgainA minus gainmid 255
RgainB gainmid 0 2.55
Xerror plus minus logic 0 error pd OA859_OPA859
Vpd pd 0 PWL(0 0 .8u 0 .801u 5)
Rlead error lead 2.94k
Clead error lead 124.7p
Rleadr lead mid 215
Eservo_monitor servo 0 mid 0 1
Ccmp lead mid 2p
* Integral target: KI=3e6 V/V/s in original high-voltage behavioral model.
* 30000/s integral of error amplifier deviation; behavioral and clamped.
.include "../models/vendor/opa810_sbomb73a/opa810_a.lib"
Vclock clock 0 PWL(0u 2.5 0.00025u 0 0.031u 0 0.0315u 5 0.0935u 5 0.094u 0 0.156u 0 0.1565u 5 0.2185u 5 0.219u 0 0.281u 0 0.2815u 5 0.3435u 5 0.344u 0 0.406u 0 0.4065u 5 0.4685u 5 0.469u 0 0.531u 0 0.5315u 5 0.5935u 5 0.594u 0 0.656u 0 0.6565u 5 0.7185u 5 0.719u 0 0.781u 0 0.7815u 5 0.8435u 5 0.844u 0 0.906u 0 0.9065u 5 0.9685u 5 0.969u 0 1.031u 0 1.0315u 5 1.0935u 5 1.094u 0 1.156u 0 1.1565u 5 1.2185u 5 1.219u 0 1.281u 0 1.2815u 5 1.3435u 5 1.344u 0 1.406u 0 1.4065u 5 1.4685u 5 1.469u 0 1.531u 0 1.5315u 5 1.5935u 5 1.594u 0 1.656u 0 1.6565u 5 1.7185u 5 1.719u 0 1.781u 0 1.7815u 5 1.8435u 5 1.844u 0 1.906u 0 1.9065u 5 1.9685u 5 1.969u 0 2.031u 0 2.0315u 5 2.0935u 5 2.094u 0 2.156u 0 2.1565u 5 2.2185u 5 2.219u 0 2.281u 0 2.2815u 5 2.3435u 5 2.344u 0 2.406u 0 2.4065u 5 2.4685u 5 2.469u 0 2.531u 0 2.5315u 5 2.5935u 5 2.594u 0 2.656u 0 2.6565u 5 2.7185u 5 2.719u 0 2.781u 0 2.7815u 5 2.8435u 5 2.844u 0 2.906u 0 2.9065u 5 2.9685u 5 2.969u 0 3.031u 0 3.0315u 5 3.0935u 5 3.094u 0 3.156u 0 3.1565u 5 3.2185u 5 3.219u 0 3.281u 0 3.2815u 5 3.3435u 5 3.344u 0 3.406u 0 3.4065u 5 3.4685u 5 3.469u 0 3.531u 0 3.5315u 5 3.5935u 5 3.594u 0 3.656u 0 3.6565u 5 3.7185u 5 3.719u 0 3.781u 0 3.7815u 5 3.8435u 5 3.844u 0 3.906u 0 3.9065u 5 3.9685u 5 3.969u 0 4.031u 0 4.0315u 5 4.0935u 5 4.094u 0 4.156u 0 4.1565u 5 4.2185u 5 4.219u 0 4.281u 0 4.2815u 5 4.3435u 5 4.344u 0 4.406u 0 4.4065u 5 4.4685u 5 4.469u 0 4.531u 0 4.5315u 5 4.5935u 5 4.594u 0 4.656u 0 4.6565u 5 4.7185u 5 4.719u 0 4.781u 0 4.7815u 5 4.8435u 5 4.844u 0 4.906u 0 4.9065u 5 4.9685u 5 4.969u 0 5.031u 0 5.0315u 5 5.0935u 5 5.094u 0 5.156u 0 5.1565u 5 5.2185u 5 5.219u 0 5.281u 0 5.2815u 5 5.3435u 5 5.344u 0 5.406u 0 5.4065u 5 5.4685u 5 5.469u 0 5.531u 0 5.5315u 5 5.5935u 5 5.594u 0 5.656u 0 5.6565u 5 5.7185u 5 5.719u 0 5.781u 0 5.7815u 5 5.8435u 5 5.844u 0 5.906u 0 5.9065u 5 5.9685u 5 5.969u 0 6.031u 0 6.0315u 5 6.0935u 5 6.094u 0 6.156u 0 6.1565u 5 6.2185u 5 6.219u 0 6.281u 0 6.2815u 5 6.3435u 5 6.344u 0 6.406u 0 6.4065u 5 6.4685u 5 6.469u 0 6.531u 0 6.5315u 5 6.5935u 5 6.594u 0 6.656u 0 6.6565u 5 6.7185u 5 6.719u 0 6.781u 0 6.7815u 5 6.8435u 5 6.844u 0 6.906u 0 6.9065u 5 6.9685u 5 6.969u 0 7.031u 0 7.0315u 5 7.0935u 5 7.094u 0 7.156u 0 7.1565u 5 7.2185u 5 7.219u 0 7.281u 0 7.2815u 5 7.3435u 5 7.344u 0 7.406u 0 7.4065u 5 7.4685u 5 7.469u 0 7.531u 0 7.5315u 5 7.5935u 5 7.594u 0 7.656u 0 7.6565u 5 7.7185u 5 7.719u 0 7.781u 0 7.7815u 5 7.8435u 5 7.844u 0 7.906u 0 7.9065u 5 7.9685u 5 7.969u 0 8.031u 0 8.0315u 5 8.0935u 5 8.094u 0 8.156u 0 8.1565u 5 8.2185u 5 8.219u 0 8.281u 0 8.2815u 5 8.3435u 5 8.344u 0 8.406u 0 8.4065u 5 8.4685u 5 8.469u 0 8.531u 0 8.5315u 5 8.5935u 5 8.594u 0 8.656u 0 8.6565u 5 8.7185u 5 8.719u 0 8.781u 0 8.7815u 5 8.8435u 5 8.844u 0 8.906u 0 8.9065u 5 8.9685u 5 8.969u 0 9.031u 0 9.0315u 5 9.0935u 5 9.094u 0 9.156u 0 9.1565u 5 9.2185u 5 9.219u 0 9.281u 0 9.2815u 5 9.3435u 5 9.344u 0 9.406u 0 9.4065u 5 9.4685u 5 9.469u 0 9.531u 0 9.5315u 5 9.5935u 5 9.594u 0 9.656u 0 9.6565u 5 9.7185u 5 9.719u 0 9.781u 0 9.7815u 5 9.8435u 5 9.844u 0 9.906u 0 9.9065u 5 9.9685u 5 9.969u 0 10.031u 0 10.0315u 5 10.0935u 5 10.094u 0 10.156u 0 10.1565u 5 10.2185u 5 10.219u 0 10.281u 0 10.2815u 5 10.3435u 5 10.344u 0 10.406u 0 10.4065u 5 10.4685u 5 10.469u 0 10.531u 0 10.5315u 5 10.5935u 5 10.594u 0 10.656u 0 10.6565u 5 10.7185u 5 10.719u 0 10.781u 0 10.7815u 5 10.8435u 5 10.844u 0 10.906u 0 10.9065u 5 10.9685u 5 10.969u 0 11.031u 0 11.0315u 5 11.0935u 5 11.094u 0 11.156u 0 11.1565u 5 11.2185u 5 11.219u 0 11.281u 0 11.2815u 5 11.3435u 5 11.344u 0 11.406u 0 11.4065u 5 11.4685u 5 11.469u 0 11.531u 0 11.5315u 5 11.5935u 5 11.594u 0 11.656u 0 11.6565u 5 11.7185u 5 11.719u 0 11.781u 0 11.7815u 5 11.8435u 5 11.844u 0 11.906u 0 11.9065u 5 11.9685u 5 11.969u 0 12.031u 0 12.0315u 5 12.0935u 5 12.094u 0 12.156u 0 12.1565u 5 12.2185u 5 12.219u 0 12.281u 0 12.2815u 5 12.3435u 5 12.344u 0 12.406u 0 12.4065u 5 12.4685u 5 12.469u 0 12.531u 0 12.5315u 5 12.5935u 5 12.594u 0 12.656u 0 12.6565u 5 12.7185u 5 12.719u 0 12.781u 0 12.7815u 5 12.8435u 5 12.844u 0 12.906u 0 12.9065u 5 12.9685u 5 12.969u 0 13.031u 0 13.0315u 5 13.0935u 5 13.094u 0 13.156u 0 13.1565u 5 13.2185u 5 13.219u 0 13.281u 0 13.2815u 5 13.3435u 5 13.344u 0 13.406u 0 13.4065u 5 13.4685u 5 13.469u 0 13.531u 0 13.5315u 5 13.5935u 5 13.594u 0 13.656u 0 13.6565u 5 13.7185u 5 13.719u 0 13.781u 0 13.7815u 5 13.8435u 5 13.844u 0 13.906u 0 13.9065u 5 13.9685u 5 13.969u 0 14.031u 0 14.0315u 5 14.0935u 5 14.094u 0 14.156u 0 14.1565u 5 14.2185u 5 14.219u 0 14.281u 0 14.2815u 5 14.3435u 5 14.344u 0 14.406u 0 14.4065u 5 14.4685u 5 14.469u 0 14.531u 0 14.5315u 5 14.5935u 5 14.594u 0 14.656u 0 14.6565u 5 14.7185u 5 14.719u 0 14.781u 0 14.7815u 5 14.8435u 5 14.844u 0 14.906u 0 14.9065u 5 14.9685u 5 14.969u 0 15.031u 0 15.0315u 5 15.0935u 5 15.094u 0 15.156u 0 15.1565u 5 15.2185u 5 15.219u 0 15.281u 0 15.2815u 5 15.3435u 5 15.344u 0 15.406u 0 15.4065u 5 15.4685u 5 15.469u 0 15.531u 0 15.5315u 5 15.5935u 5 15.594u 0 15.656u 0 15.6565u 5 15.7185u 5 15.719u 0 15.781u 0 15.7815u 5 15.8435u 5 15.844u 0 15.906u 0 15.9065u 5 15.9685u 5 15.969u 0 16.031u 0 16.0315u 5 16.0935u 5 16.094u 0 16.156u 0 16.1565u 5 16.2185u 5 16.219u 0 16.281u 0 16.2815u 5 16.3435u 5 16.344u 0 16.406u 0 16.4065u 5 16.4685u 5 16.469u 0 16.531u 0 16.5315u 5 16.5935u 5 16.594u 0 16.656u 0 16.6565u 5 16.7185u 5 16.719u 0 16.781u 0 16.7815u 5 16.8435u 5 16.844u 0 16.906u 0 16.9065u 5 16.9685u 5 16.969u 0 17.031u 0 17.0315u 5 17.0935u 5 17.094u 0 17.156u 0 17.1565u 5 17.2185u 5 17.219u 0 17.281u 0 17.2815u 5 17.3435u 5 17.344u 0 17.406u 0 17.4065u 5 17.4685u 5 17.469u 0 17.531u 0 17.5315u 5 17.5935u 5 17.594u 0 17.656u 0 17.6565u 5 17.7185u 5 17.719u 0 17.781u 0 17.7815u 5 17.8435u 5 17.844u 0 17.906u 0 17.9065u 5 17.9685u 5 17.969u 0 18.031u 0 18.0315u 5 18.0935u 5 18.094u 0 18.156u 0 18.1565u 5 18.2185u 5 18.219u 0 18.281u 0 18.2815u 5 18.3435u 5 18.344u 0 18.406u 0 18.4065u 5 18.4685u 5 18.469u 0 18.531u 0 18.5315u 5 18.5935u 5 18.594u 0 18.656u 0 18.6565u 5 18.7185u 5 18.719u 0 18.781u 0 18.7815u 5 18.8435u 5 18.844u 0 18.906u 0 18.9065u 5 18.9685u 5 18.969u 0 19.031u 0 19.0315u 5 19.0935u 5 19.094u 0 19.156u 0 19.1565u 5 19.2185u 5 19.219u 0 19.281u 0 19.2815u 5 19.3435u 5 19.344u 0 19.406u 0 19.4065u 5 19.4685u 5 19.469u 0 19.531u 0 19.5315u 5 19.5935u 5 19.594u 0 19.656u 0 19.6565u 5 19.7185u 5 19.719u 0 19.781u 0 19.7815u 5 19.8435u 5 19.844u 0 19.906u 0 19.9065u 5 19.9685u 5 19.969u 0 20.031u 0 20.0315u 5 20.0935u 5 20.094u 0 20.156u 0 20.1565u 5 20.2185u 5 20.219u 0 20.281u 0 20.2815u 5 20.3435u 5 20.344u 0 20.406u 0 20.4065u 5 20.4685u 5 20.469u 0 20.531u 0 20.5315u 5 20.5935u 5 20.594u 0 20.656u 0 20.6565u 5 20.7185u 5 20.719u 0 20.781u 0 20.7815u 5 20.8435u 5 20.844u 0 20.906u 0 20.9065u 5 20.9685u 5 20.969u 0 21.031u 0 21.0315u 5 21.0935u 5 21.094u 0 21.156u 0 21.1565u 5 21.2185u 5 21.219u 0 21.281u 0 21.2815u 5 21.3435u 5 21.344u 0 21.406u 0 21.4065u 5 21.4685u 5 21.469u 0 21.531u 0 21.5315u 5 21.5935u 5 21.594u 0 21.656u 0 21.6565u 5 21.7185u 5 21.719u 0 21.781u 0 21.7815u 5 21.8435u 5 21.844u 0 21.906u 0 21.9065u 5 21.9685u 5 21.969u 0 22.031u 0 22.0315u 5 22.0935u 5 22.094u 0 22.156u 0 22.1565u 5 22.2185u 5 22.219u 0 22.281u 0 22.2815u 5 22.3435u 5 22.344u 0 22.406u 0 22.4065u 5 22.4685u 5 22.469u 0 22.531u 0 22.5315u 5 22.5935u 5 22.594u 0 22.656u 0 22.6565u 5 22.7185u 5 22.719u 0 22.781u 0 22.7815u 5 22.8435u 5 22.844u 0 22.906u 0 22.9065u 5 22.9685u 5 22.969u 0 23.031u 0 23.0315u 5 23.0935u 5 23.094u 0 23.156u 0 23.1565u 5 23.2185u 5 23.219u 0 23.281u 0 23.2815u 5 23.3435u 5 23.344u 0 23.406u 0 23.4065u 5 23.4685u 5 23.469u 0 23.531u 0 23.5315u 5 23.5935u 5 23.594u 0 23.656u 0 23.6565u 5 23.7185u 5 23.719u 0 23.781u 0 23.7815u 5 23.8435u 5 23.844u 0 23.906u 0 23.9065u 5 23.9685u 5 23.969u 0 24.031u 0 24.0315u 5 24.0935u 5 24.094u 0 24.156u 0 24.1565u 5 24.2185u 5 24.219u 0 24.281u 0 24.2815u 5 24.3435u 5 24.344u 0 24.406u 0 24.4065u 5 24.4685u 5 24.469u 0 24.531u 0 24.5315u 5 24.5935u 5 24.594u 0 24.656u 0 24.6565u 5 24.7185u 5 24.719u 0 24.781u 0 24.7815u 5 24.8435u 5 24.844u 0 24.906u 0 24.9065u 5 24.9685u 5 24.969u 0 25.031u 0 25.0315u 5 25.0935u 5 25.094u 0 25.156u 0 25.1565u 5 25.2185u 5 25.219u 0 25.281u 0 25.2815u 5 25.3435u 5 25.344u 0 25.406u 0 25.4065u 5 25.4685u 5 25.469u 0 25.531u 0 25.5315u 5 25.5935u 5 25.594u 0 25.656u 0 25.6565u 5 25.7185u 5 25.719u 0 25.781u 0 25.7815u 5 25.8435u 5 25.844u 0 25.906u 0 25.9065u 5 25.9685u 5 25.969u 0 26.031u 0 26.0315u 5 26.0935u 5 26.094u 0 26.156u 0 26.1565u 5 26.2185u 5 26.219u 0 26.281u 0 26.2815u 5 26.3435u 5 26.344u 0 26.406u 0 26.4065u 5 26.4685u 5 26.469u 0 26.531u 0 26.5315u 5 26.5935u 5 26.594u 0 26.656u 0 26.6565u 5 26.7185u 5 26.719u 0 26.781u 0 26.7815u 5 26.8435u 5 26.844u 0 26.906u 0 26.9065u 5 26.9685u 5 26.969u 0 27.031u 0 27.0315u 5 27.0935u 5 27.094u 0 27.156u 0 27.1565u 5 27.2185u 5 27.219u 0 27.281u 0 27.2815u 5 27.3435u 5 27.344u 0 27.406u 0 27.4065u 5 27.4685u 5 27.469u 0 27.531u 0 27.5315u 5 27.5935u 5 27.594u 0 27.656u 0 27.6565u 5 27.7185u 5 27.719u 0 27.781u 0 27.7815u 5 27.8435u 5 27.844u 0 27.906u 0 27.9065u 5 27.9685u 5 27.969u 0 28.031u 0 28.0315u 5 28.0935u 5 28.094u 0 28.156u 0 28.1565u 5 28.2185u 5 28.219u 0 28.281u 0 28.2815u 5 28.3435u 5 28.344u 0 28.406u 0 28.4065u 5 28.4685u 5 28.469u 0 28.531u 0 28.5315u 5 28.5935u 5 28.594u 0 28.656u 0 28.6565u 5 28.7185u 5 28.719u 0 28.781u 0 28.7815u 5 28.8435u 5 28.844u 0 28.906u 0 28.9065u 5 28.9685u 5 28.969u 0 29.031u 0 29.0315u 5 29.0935u 5 29.094u 0 29.156u 0 29.1565u 5 29.2185u 5 29.219u 0 29.281u 0 29.2815u 5 29.3435u 5 29.344u 0 29.406u 0 29.4065u 5 29.4685u 5 29.469u 0 29.531u 0 29.5315u 5 29.5935u 5 29.594u 0 29.656u 0 29.6565u 5 29.7185u 5 29.719u 0 29.781u 0 29.7815u 5 29.8435u 5 29.844u 0 29.906u 0 29.9065u 5 29.9685u 5 29.969u 0 30.031u 0 30.0315u 5 30.0935u 5 30.094u 0 30.156u 0 30.1565u 5 30.2185u 5 30.219u 0 30.281u 0 30.2815u 5 30.3435u 5 30.344u 0 30.406u 0 30.4065u 5 30.4685u 5 30.469u 0 30.531u 0 30.5315u 5 30.5935u 5 30.594u 0 30.656u 0 30.6565u 5 30.7185u 5 30.719u 0 30.781u 0 30.7815u 5 30.8435u 5 30.844u 0 30.906u 0 30.9065u 5 30.9685u 5 30.969u 0 31.031u 0 31.0315u 5 31.0935u 5 31.094u 0 31.156u 0 31.1565u 5 31.2185u 5 31.219u 0 31.281u 0 31.2815u 5 31.3435u 5 31.344u 0 31.406u 0 31.4065u 5 31.4685u 5 31.469u 0 31.531u 0 31.5315u 5 31.5935u 5 31.594u 0 31.656u 0 31.6565u 5 31.7185u 5 31.719u 0 31.781u 0 31.7815u 5 31.8435u 5 31.844u 0 31.906u 0 31.9065u 5 31.9685u 5 31.969u 0 32.031u 0 32.0315u 5 32.0935u 5 32.094u 0 32.156u 0 32.1565u 5 32.2185u 5 32.219u 0 32.281u 0 32.2815u 5 32.3435u 5 32.344u 0 32.406u 0 32.4065u 5 32.4685u 5 32.469u 0 32.531u 0 32.5315u 5 32.5935u 5 32.594u 0 32.656u 0 32.6565u 5 32.7185u 5 32.719u 0 32.781u 0 32.7815u 5 32.8435u 5 32.844u 0 32.906u 0 32.9065u 5 32.9685u 5 32.969u 0 33.031u 0 33.0315u 5 33.0935u 5 33.094u 0 33.156u 0 33.1565u 5 33.2185u 5 33.219u 0 33.281u 0 33.2815u 5 33.3435u 5 33.344u 0 33.406u 0 33.4065u 5 33.4685u 5 33.469u 0 33.531u 0 33.5315u 5 33.5935u 5 33.594u 0 33.656u 0 33.6565u 5 33.7185u 5 33.719u 0 33.781u 0 33.7815u 5 33.8435u 5 33.844u 0 33.906u 0 33.9065u 5 33.9685u 5 33.969u 0 34.031u 0 34.0315u 5 34.0935u 5 34.094u 0 34.156u 0 34.1565u 5 34.2185u 5 34.219u 0 34.281u 0 34.2815u 5 34.3435u 5 34.344u 0 34.406u 0 34.4065u 5 34.4685u 5 34.469u 0 34.531u 0 34.5315u 5 34.5935u 5 34.594u 0 34.656u 0 34.6565u 5 34.7185u 5 34.719u 0 34.781u 0 34.7815u 5 34.8435u 5 34.844u 0 34.906u 0 34.9065u 5 34.9685u 5 34.969u 0 35.031u 0 35.0315u 5 35.0935u 5 35.094u 0 35.156u 0 35.1565u 5 35.2185u 5 35.219u 0 35.281u 0 35.2815u 5 35.3435u 5 35.344u 0 35.406u 0 35.4065u 5 35.4685u 5 35.469u 0 35.531u 0 35.5315u 5 35.5935u 5 35.594u 0 35.656u 0 35.6565u 5 35.7185u 5 35.719u 0 35.781u 0 35.7815u 5 35.8435u 5 35.844u 0 35.906u 0 35.9065u 5 35.9685u 5 35.969u 0 36.031u 0 36.0315u 5 36.0935u 5 36.094u 0 36.156u 0 36.1565u 5 36.2185u 5 36.219u 0 36.281u 0 36.2815u 5 36.3435u 5 36.344u 0 36.406u 0 36.4065u 5 36.4685u 5 36.469u 0 36.531u 0 36.5315u 5 36.5935u 5 36.594u 0 36.656u 0 36.6565u 5 36.7185u 5 36.719u 0 36.781u 0 36.7815u 5 36.8435u 5 36.844u 0 36.906u 0 36.9065u 5 36.9685u 5 36.969u 0 37.031u 0 37.0315u 5 37.0935u 5 37.094u 0 37.156u 0 37.1565u 5 37.2185u 5 37.219u 0 37.281u 0 37.2815u 5 37.3435u 5 37.344u 0 37.406u 0 37.4065u 5 37.4685u 5 37.469u 0 37.531u 0 37.5315u 5 37.5935u 5 37.594u 0 37.656u 0 37.6565u 5 37.7185u 5 37.719u 0 37.781u 0 37.7815u 5 37.8435u 5 37.844u 0 37.906u 0 37.9065u 5 37.9685u 5 37.969u 0 38.031u 0 38.0315u 5 38.0935u 5 38.094u 0 38.156u 0 38.1565u 5 38.2185u 5 38.219u 0 38.281u 0 38.2815u 5 38.3435u 5 38.344u 0 38.406u 0 38.4065u 5 38.4685u 5 38.469u 0 38.531u 0 38.5315u 5 38.5935u 5 38.594u 0 38.656u 0 38.6565u 5 38.7185u 5 38.719u 0 38.781u 0 38.7815u 5 38.8435u 5 38.844u 0 38.906u 0 38.9065u 5 38.9685u 5 38.969u 0 39.031u 0 39.0315u 5 39.0935u 5 39.094u 0 39.156u 0 39.1565u 5 39.2185u 5 39.219u 0 39.281u 0 39.2815u 5 39.3435u 5 39.344u 0 39.406u 0 39.4065u 5 39.4685u 5 39.469u 0 39.531u 0 39.5315u 5 39.5935u 5 39.594u 0 39.656u 0 39.6565u 5 39.7185u 5 39.719u 0 39.781u 0 39.7815u 5 39.8435u 5 39.844u 0 39.906u 0 39.9065u 5 39.9685u 5 39.969u 0 40.031u 0 40.0315u 5 40.0935u 5 40.094u 0 40.156u 0 40.1565u 5 40.2185u 5 40.219u 0 40.281u 0 40.2815u 5 40.3435u 5 40.344u 0 40.406u 0 40.4065u 5 40.4685u 5 40.469u 0 40.531u 0 40.5315u 5 40.5935u 5 40.594u 0 40.656u 0 40.6565u 5 40.7185u 5 40.719u 0 40.781u 0 40.7815u 5 40.8435u 5 40.844u 0 40.906u 0 40.9065u 5 40.9685u 5 40.969u 0 41.031u 0 41.0315u 5 41.0935u 5 41.094u 0 41.156u 0 41.1565u 5 41.2185u 5 41.219u 0 41.281u 0 41.2815u 5 41.3435u 5 41.344u 0 41.406u 0 41.4065u 5 41.4685u 5 41.469u 0 41.531u 0 41.5315u 5 41.5935u 5 41.594u 0 41.656u 0 41.6565u 5 41.7185u 5 41.719u 0 41.781u 0 41.7815u 5 41.8435u 5 41.844u 0 41.906u 0 41.9065u 5 41.9685u 5 41.969u 0 42.031u 0 42.0315u 5 42.0935u 5 42.094u 0 42.156u 0 42.1565u 5 42.2185u 5 42.219u 0 42.281u 0 42.2815u 5 42.3435u 5 42.344u 0 42.406u 0 42.4065u 5 42.4685u 5 42.469u 0 42.531u 0 42.5315u 5 42.5935u 5 42.594u 0 42.656u 0 42.6565u 5 42.7185u 5 42.719u 0 42.781u 0 42.7815u 5 42.8435u 5 42.844u 0 42.906u 0 42.9065u 5 42.9685u 5 42.969u 0 43.031u 0 43.0315u 5 43.0935u 5 43.094u 0 43.156u 0 43.1565u 5 43.2185u 5 43.219u 0 43.281u 0 43.2815u 5 43.3435u 5 43.344u 0 43.406u 0 43.4065u 5 43.4685u 5 43.469u 0 43.531u 0 43.5315u 5 43.5935u 5 43.594u 0 43.656u 0 43.6565u 5 43.7185u 5 43.719u 0 43.781u 0 43.7815u 5 43.8435u 5 43.844u 0 43.906u 0 43.9065u 5 43.9685u 5 43.969u 0 44.031u 0 44.0315u 5 44.0935u 5 44.094u 0 44.156u 0 44.1565u 5 44.2185u 5 44.219u 0 44.281u 0 44.2815u 5 44.3435u 5 44.344u 0 44.406u 0 44.4065u 5 44.4685u 5 44.469u 0 44.531u 0 44.5315u 5 44.5935u 5 44.594u 0 44.656u 0 44.6565u 5 44.7185u 5 44.719u 0 44.781u 0 44.7815u 5 44.8435u 5 44.844u 0 44.906u 0 44.9065u 5 44.9685u 5 44.969u 0 45.031u 0 45.0315u 5 45.0935u 5 45.094u 0 45.156u 0 45.1565u 5 45.2185u 5 45.219u 0 45.281u 0 45.2815u 5 45.3435u 5 45.344u 0 45.406u 0 45.4065u 5 45.4685u 5 45.469u 0 45.531u 0 45.5315u 5 45.5935u 5 45.594u 0 45.656u 0 45.6565u 5 45.7185u 5 45.719u 0 45.781u 0 45.7815u 5 45.8435u 5 45.844u 0 45.906u 0 45.9065u 5 45.9685u 5 45.969u 0 46.031u 0 46.0315u 5 46.0935u 5 46.094u 0 46.156u 0 46.1565u 5 46.2185u 5 46.219u 0 46.281u 0 46.2815u 5 46.3435u 5 46.344u 0 46.406u 0 46.4065u 5 46.4685u 5 46.469u 0 46.531u 0 46.5315u 5 46.5935u 5 46.594u 0 46.656u 0 46.6565u 5 46.7185u 5 46.719u 0 46.781u 0 46.7815u 5 46.8435u 5 46.844u 0 46.906u 0 46.9065u 5 46.9685u 5 46.969u 0 47.031u 0 47.0315u 5 47.0935u 5 47.094u 0 47.156u 0 47.1565u 5 47.2185u 5 47.219u 0 47.281u 0 47.2815u 5 47.3435u 5 47.344u 0 47.406u 0 47.4065u 5 47.4685u 5 47.469u 0 47.531u 0 47.5315u 5 47.5935u 5 47.594u 0 47.656u 0 47.6565u 5 47.7185u 5 47.719u 0 47.781u 0 47.7815u 5 47.8435u 5 47.844u 0 47.906u 0 47.9065u 5 47.9685u 5 47.969u 0 48.031u 0 48.0315u 5 48.0935u 5 48.094u 0 48.156u 0 48.1565u 5 48.2185u 5 48.219u 0 48.281u 0 48.2815u 5 48.3435u 5 48.344u 0 48.406u 0 48.4065u 5 48.4685u 5 48.469u 0 48.531u 0 48.5315u 5 48.5935u 5 48.594u 0 48.656u 0 48.6565u 5 48.7185u 5 48.719u 0 48.781u 0 48.7815u 5 48.8435u 5 48.844u 0 48.906u 0 48.9065u 5 48.9685u 5 48.969u 0 49.031u 0 49.0315u 5 49.0935u 5 49.094u 0 49.156u 0 49.1565u 5 49.2185u 5 49.219u 0 49.281u 0 49.2815u 5 49.3435u 5 49.344u 0 49.406u 0 49.4065u 5 49.4685u 5 49.469u 0 49.531u 0 49.5315u 5 49.5935u 5 49.594u 0 49.656u 0 49.6565u 5 49.7185u 5 49.719u 0 49.781u 0 49.7815u 5 49.8435u 5 49.844u 0 49.906u 0 49.9065u 5 49.9685u 5 49.969u 0 50.031u 0 50.0315u 5 50.0935u 5 50.094u 0 50.156u 0 50.1565u 5 50.2185u 5 50.219u 0 50.281u 0 50.2815u 5 50.3435u 5 50.344u 0 50.406u 0 50.4065u 5 50.4685u 5 50.469u 0 50.531u 0 50.5315u 5 50.5935u 5 50.594u 0 50.656u 0 50.6565u 5 50.7185u 5 50.719u 0 50.781u 0 50.7815u 5 50.8435u 5 50.844u 0 50.906u 0 50.9065u 5 50.9685u 5 50.969u 0 51.031u 0 51.0315u 5 51.0935u 5 51.094u 0 51.156u 0 51.1565u 5 51.2185u 5 51.219u 0 51.281u 0 51.2815u 5 51.3435u 5 51.344u 0 51.406u 0 51.4065u 5 51.4685u 5 51.469u 0 51.531u 0 51.5315u 5 51.5935u 5 51.594u 0 51.656u 0 51.6565u 5 51.7185u 5 51.719u 0 51.781u 0 51.7815u 5 51.8435u 5 51.844u 0 51.906u 0 51.9065u 5 51.9685u 5 51.969u 0 52.031u 0 52.0315u 5 52.0935u 5 52.094u 0 52.156u 0 52.1565u 5 52.2185u 5 52.219u 0 52.281u 0 52.2815u 5 52.3435u 5 52.344u 0 52.406u 0 52.4065u 5 52.4685u 5 52.469u 0 52.531u 0 52.5315u 5 52.5935u 5 52.594u 0 52.656u 0 52.6565u 5 52.7185u 5 52.719u 0 52.781u 0 52.7815u 5 52.8435u 5 52.844u 0 52.906u 0 52.9065u 5 52.9685u 5 52.969u 0 53.031u 0 53.0315u 5 53.0935u 5 53.094u 0 53.156u 0 53.1565u 5 53.2185u 5 53.219u 0 53.281u 0 53.2815u 5 53.3435u 5 53.344u 0 53.406u 0 53.4065u 5 53.4685u 5 53.469u 0 53.531u 0 53.5315u 5 53.5935u 5 53.594u 0 53.656u 0 53.6565u 5 53.7185u 5 53.719u 0 53.781u 0 53.7815u 5 53.8435u 5 53.844u 0 53.906u 0 53.9065u 5 53.9685u 5 53.969u 0 54.031u 0 54.0315u 5 54.0935u 5 54.094u 0 54.156u 0 54.1565u 5 54.2185u 5 54.219u 0 54.281u 0 54.2815u 5 54.3435u 5 54.344u 0 54.406u 0 54.4065u 5 54.4685u 5 54.469u 0 54.531u 0 54.5315u 5 54.5935u 5 54.594u 0 54.656u 0 54.6565u 5 54.7185u 5 54.719u 0 54.781u 0 54.7815u 5 54.8435u 5 54.844u 0 54.906u 0 54.9065u 5 54.9685u 5 54.969u 0 55.031u 0 55.0315u 5 55.0935u 5 55.094u 0 55.156u 0 55.1565u 5 55.2185u 5 55.219u 0 55.281u 0 55.2815u 5 55.3435u 5 55.344u 0 55.406u 0 55.4065u 5 55.4685u 5 55.469u 0 55.531u 0 55.5315u 5 55.5935u 5 55.594u 0 55.656u 0 55.6565u 5 55.7185u 5 55.719u 0 55.781u 0 55.7815u 5 55.8435u 5 55.844u 0 55.906u 0 55.9065u 5 55.9685u 5 55.969u 0 56.031u 0 56.0315u 5 56.0935u 5 56.094u 0 56.156u 0 56.1565u 5 56.2185u 5 56.219u 0 56.281u 0 56.2815u 5 56.3435u 5 56.344u 0 56.406u 0 56.4065u 5 56.4685u 5 56.469u 0 56.531u 0 56.5315u 5 56.5935u 5 56.594u 0 56.656u 0 56.6565u 5 56.7185u 5 56.719u 0 56.781u 0 56.7815u 5 56.8435u 5 56.844u 0 56.906u 0 56.9065u 5 56.9685u 5 56.969u 0 57.031u 0 57.0315u 5 57.0935u 5 57.094u 0 57.156u 0 57.1565u 5 57.2185u 5 57.219u 0 57.281u 0 57.2815u 5 57.3435u 5 57.344u 0 57.406u 0 57.4065u 5 57.4685u 5 57.469u 0 57.531u 0 57.5315u 5 57.5935u 5 57.594u 0 57.656u 0 57.6565u 5 57.7185u 5 57.719u 0 57.781u 0 57.7815u 5 57.8435u 5 57.844u 0 57.906u 0 57.9065u 5 57.9685u 5 57.969u 0 58.031u 0 58.0315u 5 58.0935u 5 58.094u 0 58.156u 0 58.1565u 5 58.2185u 5 58.219u 0 58.281u 0 58.2815u 5 58.3435u 5 58.344u 0 58.406u 0 58.4065u 5 58.4685u 5 58.469u 0 58.531u 0 58.5315u 5 58.5935u 5 58.594u 0 58.656u 0 58.6565u 5 58.7185u 5 58.719u 0 58.781u 0 58.7815u 5 58.8435u 5 58.844u 0 58.906u 0 58.9065u 5 58.9685u 5 58.969u 0 59.031u 0 59.0315u 5 59.0935u 5 59.094u 0 59.156u 0 59.1565u 5 59.2185u 5 59.219u 0 59.281u 0 59.2815u 5 59.3435u 5 59.344u 0 59.406u 0 59.4065u 5 59.4685u 5 59.469u 0 59.531u 0 59.5315u 5 59.5935u 5 59.594u 0 59.656u 0 59.6565u 5 59.7185u 5 59.719u 0 59.781u 0 59.7815u 5 59.8435u 5 59.844u 0 59.906u 0 59.9065u 5 59.9685u 5 59.969u 0 60.031u 0 60.0315u 5 60.0935u 5 60.094u 0 60.156u 0 60.1565u 5 60.2185u 5 60.219u 0 60.281u 0 60.2815u 5 60.3435u 5 60.344u 0 60.406u 0 60.4065u 5 60.4685u 5 60.469u 0 60.531u 0 60.5315u 5 60.5935u 5 60.594u 0 60.656u 0 60.6565u 5 60.7185u 5 60.719u 0 60.781u 0 60.7815u 5 60.8435u 5 60.844u 0 60.906u 0 60.9065u 5 60.9685u 5 60.969u 0 61.031u 0 61.0315u 5 61.0935u 5 61.094u 0 61.156u 0 61.1565u 5 61.2185u 5 61.219u 0 61.281u 0 61.2815u 5 61.3435u 5 61.344u 0 61.406u 0 61.4065u 5 61.4685u 5 61.469u 0 61.531u 0 61.5315u 5 61.5935u 5 61.594u 0 61.656u 0 61.6565u 5 61.7185u 5 61.719u 0 61.781u 0 61.7815u 5 61.8435u 5 61.844u 0 61.906u 0 61.9065u 5 61.9685u 5 61.969u 0 62.031u 0 62.0315u 5 62.0935u 5 62.094u 0 62.156u 0 62.1565u 5 62.2185u 5 62.219u 0 62.281u 0 62.2815u 5 62.3435u 5 62.344u 0 62.406u 0 62.4065u 5 62.4685u 5 62.469u 0 62.531u 0 62.5315u 5 62.5935u 5 62.594u 0 62.656u 0 62.6565u 5 62.7185u 5 62.719u 0 62.781u 0 62.7815u 5 62.8435u 5 62.844u 0 62.906u 0 62.9065u 5 62.9685u 5 62.969u 0 63.031u 0 63.0315u 5 63.0935u 5 63.094u 0 63.156u 0 63.1565u 5 63.2185u 5 63.219u 0 63.281u 0 63.2815u 5 63.3435u 5 63.344u 0 63.406u 0 63.4065u 5 63.4685u 5 63.469u 0 63.531u 0 63.5315u 5 63.5935u 5 63.594u 0 63.656u 0 63.6565u 5 63.7185u 5 63.719u 0 63.781u 0 63.7815u 5 63.8435u 5 63.844u 0 63.906u 0 63.9065u 5 63.9685u 5 63.969u 0 64.031u 0 64.0315u 5 64.0935u 5 64.094u 0 64.156u 0 64.1565u 5 64.2185u 5 64.219u 0 64.281u 0 64.2815u 5 64.3435u 5 64.344u 0 64.406u 0 64.4065u 5 64.4685u 5 64.469u 0 64.531u 0 64.5315u 5 64.5935u 5 64.594u 0 64.656u 0 64.6565u 5 64.7185u 5 64.719u 0 64.781u 0 64.7815u 5 64.8435u 5 64.844u 0 64.906u 0 64.9065u 5 64.9685u 5 64.969u 0 65.031u 0 65.0315u 5 65.0935u 5 65.094u 0 65.156u 0 65.1565u 5 65.2185u 5 65.219u 0 65.281u 0 65.2815u 5 65.3435u 5 65.344u 0 65.406u 0 65.4065u 5 65.4685u 5 65.469u 0 65.531u 0 65.5315u 5 65.5935u 5 65.594u 0 65.656u 0 65.6565u 5 65.7185u 5 65.719u 0 65.781u 0 65.7815u 5 65.8435u 5 65.844u 0 65.906u 0 65.9065u 5 65.9685u 5 65.969u 0 66.031u 0 66.0315u 5 66.0935u 5 66.094u 0 66.156u 0 66.1565u 5 66.2185u 5 66.219u 0 66.281u 0 66.2815u 5 66.3435u 5 66.344u 0 66.406u 0 66.4065u 5 66.4685u 5 66.469u 0 66.531u 0 66.5315u 5 66.5935u 5 66.594u 0 66.656u 0 66.6565u 5 66.7185u 5 66.719u 0 66.781u 0 66.7815u 5 66.8435u 5 66.844u 0 66.906u 0 66.9065u 5 66.9685u 5 66.969u 0 67.031u 0 67.0315u 5 67.0935u 5 67.094u 0 67.156u 0 67.1565u 5 67.2185u 5 67.219u 0 67.281u 0 67.2815u 5 67.3435u 5 67.344u 0 67.406u 0 67.4065u 5 67.4685u 5 67.469u 0 67.531u 0 67.5315u 5 67.5935u 5 67.594u 0 67.656u 0 67.6565u 5 67.7185u 5 67.719u 0 67.781u 0 67.7815u 5 67.8435u 5 67.844u 0 67.906u 0 67.9065u 5 67.9685u 5 67.969u 0 68.031u 0 68.0315u 5 68.0935u 5 68.094u 0 68.156u 0 68.1565u 5 68.2185u 5 68.219u 0 68.281u 0 68.2815u 5 68.3435u 5 68.344u 0 68.406u 0 68.4065u 5 68.4685u 5 68.469u 0 68.531u 0 68.5315u 5 68.5935u 5 68.594u 0 68.656u 0 68.6565u 5 68.7185u 5 68.719u 0 68.781u 0 68.7815u 5 68.8435u 5 68.844u 0 68.906u 0 68.9065u 5 68.9685u 5 68.969u 0 69.031u 0 69.0315u 5 69.0935u 5 69.094u 0 69.156u 0 69.1565u 5 69.2185u 5 69.219u 0 69.281u 0 69.2815u 5 69.3435u 5 69.344u 0 69.406u 0 69.4065u 5 69.4685u 5 69.469u 0 69.531u 0 69.5315u 5 69.5935u 5 69.594u 0 69.656u 0 69.6565u 5 69.7185u 5 69.719u 0 69.781u 0 69.7815u 5 69.8435u 5 69.844u 0 69.906u 0 69.9065u 5 69.9685u 5 69.969u 0 70.031u 0 70.0315u 5 70.0935u 5 70.094u 0 70.156u 0 70.1565u 5 70.2185u 5 70.219u 0 70.281u 0 70.2815u 5 70.3435u 5 70.344u 0 70.406u 0 70.4065u 5 70.4685u 5 70.469u 0 70.531u 0 70.5315u 5 70.5935u 5 70.594u 0 70.656u 0 70.6565u 5 70.7185u 5 70.719u 0 70.781u 0 70.7815u 5 70.8435u 5 70.844u 0 70.906u 0 70.9065u 5 70.9685u 5 70.969u 0 71.031u 0 71.0315u 5 71.0935u 5 71.094u 0 71.156u 0 71.1565u 5 71.2185u 5 71.219u 0 71.281u 0 71.2815u 5 71.3435u 5 71.344u 0 71.406u 0 71.4065u 5 71.4685u 5 71.469u 0 71.531u 0 71.5315u 5 71.5935u 5 71.594u 0 71.656u 0 71.6565u 5 71.7185u 5 71.719u 0 71.781u 0 71.7815u 5 71.8435u 5 71.844u 0 71.906u 0 71.9065u 5 71.9685u 5 71.969u 0 72.031u 0 72.0315u 5 72.0935u 5 72.094u 0 72.156u 0 72.1565u 5 72.2185u 5 72.219u 0 72.281u 0 72.2815u 5 72.3435u 5 72.344u 0 72.406u 0 72.4065u 5 72.4685u 5 72.469u 0 72.531u 0 72.5315u 5 72.5935u 5 72.594u 0 72.656u 0 72.6565u 5 72.7185u 5 72.719u 0 72.781u 0 72.7815u 5 72.8435u 5 72.844u 0 72.906u 0 72.9065u 5 72.9685u 5 72.969u 0 73.031u 0 73.0315u 5 73.0935u 5 73.094u 0 73.156u 0 73.1565u 5 73.2185u 5 73.219u 0 73.281u 0 73.2815u 5 73.3435u 5 73.344u 0 73.406u 0 73.4065u 5 73.4685u 5 73.469u 0 73.531u 0 73.5315u 5 73.5935u 5 73.594u 0 73.656u 0 73.6565u 5 73.7185u 5 73.719u 0 73.781u 0 73.7815u 5 73.8435u 5 73.844u 0 73.906u 0 73.9065u 5 73.9685u 5 73.969u 0 74.031u 0 74.0315u 5 74.0935u 5 74.094u 0 74.156u 0 74.1565u 5 74.2185u 5 74.219u 0 74.281u 0 74.2815u 5 74.3435u 5 74.344u 0 74.406u 0 74.4065u 5 74.4685u 5 74.469u 0 74.531u 0 74.5315u 5 74.5935u 5 74.594u 0 74.656u 0 74.6565u 5 74.7185u 5 74.719u 0 74.781u 0 74.7815u 5 74.8435u 5 74.844u 0 74.906u 0 74.9065u 5 74.9685u 5 74.969u 0 75.031u 0 75.0315u 5 75.0935u 5 75.094u 0 75.156u 0 75.1565u 5 75.2185u 5 75.219u 0 75.281u 0 75.2815u 5 75.3435u 5 75.344u 0 75.406u 0 75.4065u 5 75.4685u 5 75.469u 0 75.531u 0 75.5315u 5 75.5935u 5 75.594u 0 75.656u 0 75.6565u 5 75.7185u 5 75.719u 0 75.781u 0 75.7815u 5 75.8435u 5 75.844u 0 75.906u 0 75.9065u 5 75.9685u 5 75.969u 0 76.031u 0 76.0315u 5 76.0935u 5 76.094u 0 76.156u 0 76.1565u 5 76.2185u 5 76.219u 0 76.281u 0 76.2815u 5 76.3435u 5 76.344u 0 76.406u 0 76.4065u 5 76.4685u 5 76.469u 0 76.531u 0 76.5315u 5 76.5935u 5 76.594u 0 76.656u 0 76.6565u 5 76.7185u 5 76.719u 0 76.781u 0 76.7815u 5 76.8435u 5 76.844u 0 76.906u 0 76.9065u 5 76.9685u 5 76.969u 0 77.031u 0 77.0315u 5 77.0935u 5 77.094u 0 77.156u 0 77.1565u 5 77.2185u 5 77.219u 0 77.281u 0 77.2815u 5 77.3435u 5 77.344u 0 77.406u 0 77.4065u 5 77.4685u 5 77.469u 0 77.531u 0 77.5315u 5 77.5935u 5 77.594u 0 77.656u 0 77.6565u 5 77.7185u 5 77.719u 0 77.781u 0 77.7815u 5 77.8435u 5 77.844u 0 77.906u 0 77.9065u 5 77.9685u 5 77.969u 0 78.031u 0 78.0315u 5 78.0935u 5 78.094u 0 78.156u 0 78.1565u 5 78.2185u 5 78.219u 0 78.281u 0 78.2815u 5 78.3435u 5 78.344u 0 78.406u 0 78.4065u 5 78.4685u 5 78.469u 0 78.531u 0 78.5315u 5 78.5935u 5 78.594u 0 78.656u 0 78.6565u 5 78.7185u 5 78.719u 0 78.781u 0 78.7815u 5 78.8435u 5 78.844u 0 78.906u 0 78.9065u 5 78.9685u 5 78.969u 0 79.031u 0 79.0315u 5 79.0935u 5 79.094u 0 79.156u 0 79.1565u 5 79.2185u 5 79.219u 0 79.281u 0 79.2815u 5 79.3435u 5 79.344u 0 79.406u 0 79.4065u 5 79.4685u 5 79.469u 0 79.531u 0 79.5315u 5 79.5935u 5 79.594u 0 79.656u 0 79.6565u 5 79.7185u 5 79.719u 0 79.781u 0 79.7815u 5 79.8435u 5 79.844u 0 79.906u 0 79.9065u 5 79.9685u 5 79.969u 0 80.031u 0 80.0315u 5 80.0935u 5 80.094u 0 80.156u 0 80.1565u 5 80.2185u 5 80.219u 0 80.281u 0 80.2815u 5 80.3435u 5 80.344u 0 80.406u 0 80.4065u 5 80.4685u 5 80.469u 0 80.531u 0 80.5315u 5 80.5935u 5 80.594u 0 80.656u 0 80.6565u 5 80.7185u 5 80.719u 0 80.781u 0 80.7815u 5 80.8435u 5 80.844u 0 80.906u 0 80.9065u 5 80.9685u 5 80.969u 0 81.031u 0 81.0315u 5 81.0935u 5 81.094u 0 81.156u 0 81.1565u 5 81.2185u 5 81.219u 0 81.281u 0 81.2815u 5 81.3435u 5 81.344u 0 81.406u 0 81.4065u 5 81.4685u 5 81.469u 0 81.531u 0 81.5315u 5 81.5935u 5 81.594u 0 81.656u 0 81.6565u 5 81.7185u 5 81.719u 0 81.781u 0 81.7815u 5 81.8435u 5 81.844u 0 81.906u 0 81.9065u 5 81.9685u 5 81.969u 0 82.031u 0 82.0315u 5 82.0935u 5 82.094u 0 82.156u 0 82.1565u 5 82.2185u 5 82.219u 0 82.281u 0 82.2815u 5 82.3435u 5 82.344u 0 82.406u 0 82.4065u 5 82.4685u 5 82.469u 0 82.531u 0 82.5315u 5 82.5935u 5 82.594u 0 82.656u 0 82.6565u 5 82.7185u 5 82.719u 0 82.781u 0 82.7815u 5 82.8435u 5 82.844u 0 82.906u 0 82.9065u 5 82.9685u 5 82.969u 0 83.031u 0 83.0315u 5 83.0935u 5 83.094u 0 83.156u 0 83.1565u 5 83.2185u 5 83.219u 0 83.281u 0 83.2815u 5 83.3435u 5 83.344u 0 83.406u 0 83.4065u 5 83.4685u 5 83.469u 0 83.531u 0 83.5315u 5 83.5935u 5 83.594u 0 83.656u 0 83.6565u 5 83.7185u 5 83.719u 0 83.781u 0 83.7815u 5 83.8435u 5 83.844u 0 83.906u 0 83.9065u 5 83.9685u 5 83.969u 0 84.031u 0 84.0315u 5 84.0935u 5 84.094u 0 84.156u 0 84.1565u 5 84.2185u 5 84.219u 0 84.281u 0 84.2815u 5 84.3435u 5 84.344u 0 84.406u 0 84.4065u 5 84.4685u 5 84.469u 0 84.531u 0 84.5315u 5 84.5935u 5 84.594u 0 84.656u 0 84.6565u 5 84.7185u 5 84.719u 0 84.781u 0 84.7815u 5 84.8435u 5 84.844u 0 84.906u 0 84.9065u 5 84.9685u 5 84.969u 0 85.031u 0 85.0315u 5 85.0935u 5 85.094u 0 85.156u 0 85.1565u 5 85.2185u 5 85.219u 0 85.281u 0 85.2815u 5 85.3435u 5 85.344u 0 85.406u 0 85.4065u 5 85.4685u 5 85.469u 0 85.531u 0 85.5315u 5 85.5935u 5 85.594u 0 85.656u 0 85.6565u 5 85.7185u 5 85.719u 0 85.781u 0 85.7815u 5 85.8435u 5 85.844u 0 85.906u 0 85.9065u 5 85.9685u 5 85.969u 0 86.031u 0 86.0315u 5 86.0935u 5 86.094u 0 86.156u 0 86.1565u 5 86.2185u 5 86.219u 0 86.281u 0 86.2815u 5 86.3435u 5 86.344u 0 86.406u 0 86.4065u 5 86.4685u 5 86.469u 0 86.531u 0 86.5315u 5 86.5935u 5 86.594u 0 86.656u 0 86.6565u 5 86.7185u 5 86.719u 0 86.781u 0 86.7815u 5 86.8435u 5 86.844u 0 86.906u 0 86.9065u 5 86.9685u 5 86.969u 0 87.031u 0 87.0315u 5 87.0935u 5 87.094u 0 87.156u 0 87.1565u 5 87.2185u 5 87.219u 0 87.281u 0 87.2815u 5 87.3435u 5 87.344u 0 87.406u 0 87.4065u 5 87.4685u 5 87.469u 0 87.531u 0 87.5315u 5 87.5935u 5 87.594u 0 87.656u 0 87.6565u 5 87.7185u 5 87.719u 0 87.781u 0 87.7815u 5 87.8435u 5 87.844u 0 87.906u 0 87.9065u 5 87.9685u 5 87.969u 0 88.031u 0 88.0315u 5 88.0935u 5 88.094u 0 88.156u 0 88.1565u 5 88.2185u 5 88.219u 0)
* AC coupled clock rejects clock DC level/duty imbalance.
* DC=2.5 models an already charged coupling capacitor, NOT cold startup.
Cclock clock clockac 100n
RclockA clockac clockr 14.3k
RclockB clockr tsum 169
Ctriangle tsum triangle 54p
Rtriangle tsum triangle 49.9k
Xtriangle mid tsum triangle logic 0 OPA810
.include "../models/compatible/TLV3603.lib"
Xcmp mix triangle logic 0 rawcmp logic CMP3603_TLV3603
Rcmp rawcmp 0 10k
Rhys rawcmp mix 100Meg
Rmixlead lead mix 13.3k
Rmixref rnorm mix 100k
Rmixhi logic mix 158k
Rmixlo mix 0 113k
Bcommand command 0 V=780*V(lead,mid)
.model SWMOD SW(Ron=.0135 Roff=1e9 Vt=.5 Vh=0)
.model REV D(Is=1e-13 N=2 Rs=.006 Cjo=0 Tt=0)
.include "../models/compatible/EPC2214.lib"
.include "../models/compatible/LMG1210.lib"
.include "../models/vendor/bat46wj/BAT46WJ.lib"
Venable en 0 5
Vrun run 0 PWL(0 0 1u 0 1.001u 5)
Bdrive gate_src 0 V=V(rawcmp)*(V(run)>2.5)
Tgate gate_src 0 pwmsrc 0 Z0=1k TD=3n
Rgate_term pwmsrc 0 1k
Rpwm pwmsrc pwm1 33
Cpwm pwm1 0 3p
* TI macro exposes thermal-pad placeholders which are grounded internally.
* Bind them to model ground here; physical HS thermal pad follows datasheet HS.
Xdriver hb ho pwm1 sw1 sw1 sw1 sw1 0 0 logic lo dhl dlh logic 0 0 en 0 0 0 bst DRV1210_LMG1210
Rdhl dhl 0 100k
Rdlh dlh 0 100k
Cdriver logic 0 9.4u
Edrv_monitor vdrv 0 logic 0 1
Cboot hb sw1 1u
Dboot bst hb BAT46WJ
Rgh ho gh .51
Rgl lo gl .51
Rghoff gh sw1 10k
Rgloff gl 0 10k
Lbusfeed bus busfeed 2n
Rbusfeed busfeed buslocal .01
Llocalcap buslocal clocalx .5n
Rlocalcap clocalx clocaly .05
Clocalcap clocaly 0 20n
Vqh buslocal hd 0
Xhigh gh hd sw1 FET2214_EPC2214
Vql sw1 ld 0
Xlow gl ld 0 FET2214_EPC2214
L1 sw1 coilend {LPH}
Rcoil coilend shunt .0165
Rshunt shunt lx1 .001
RdampA lx1 out .22
RdampB lx1 out .22

Cfixed out sysgnd {CFIX}
Rcable out cable 0.22
Lcable cable head 10n
Cload head sysgnd 1n
Rleak head sysgnd 10Meg
.options reltol=1e-3 abstol=1e-8 vntol=1e-6 method=trap
.options solver=alt
.options threads=1 numdgt=7 plotwinsize=0
.tran 0 49.1u 0 1n
.save V(triangle) V(mix) V(rnorm) V(buslocal) I(Lcable) V(ref) V(head) V(out) I(L1) V(pwm1) V(error) V(servo) V(lead) V(sw1) V(vdrv) V(hb) V(gh) V(gl) I(Vbus) I(Vground) I(Vlogic) I(Vqh) I(Vql)
.end
